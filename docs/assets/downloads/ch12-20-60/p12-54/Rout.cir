P12 Rout: textbook equivalent; see README.md
Iin 0 in 0 AC 0
Rs in 0 25000
Rc1 b2 0 40000
Rc2 out 0 2000
RL out 0 500
Re2 e2 0 1000
Rf in e2 37636.7583
Rpi1 in 0 15730
Gm1 b2 0 in 0 0.0076287349
Rpi2 b2 e2 3064.16213
Gm2 out e2 b2 e2 0.0391624186
Itest 0 out 0 AC 1
.ac dec 1 1 1Meg
.options numdgt=15 measdgt=12
.meas AC rout_port FIND re(V(out)) AT=1k
.end
