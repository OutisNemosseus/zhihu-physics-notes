P12 Rout: textbook equivalent; see README.md
Vin in 0 0 AC 0
Rf e3 0 10000
Rc2 b3 0 18600
Rc3 out 0 2000
RL out 0 1000
Rpi1 in tail 5098.55377
Gm1 0 tail in tail 0.019613405
Rpi2 e3 tail 5414.96907
Gm2 b3 tail e3 tail 0.0184673262
Rpi3 b3 e3 1309.85536
Gm3 out e3 b3 e3 0.0763443071
Itest 0 out 0 AC 1
.ac dec 1 1 1Meg
.options numdgt=15 measdgt=12
.meas AC rout_port FIND re(V(out)) AT=1k
.end
