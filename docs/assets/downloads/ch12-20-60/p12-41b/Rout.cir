P12 Rout: textbook equivalent; see README.md
Vin in 0 0 AC 0
Rs out 0 1500
Gm 0 out in out 0.00328633535
Itest 0 out 0 AC 1
.ac dec 1 1 1Meg
.options numdgt=15 measdgt=12
.meas AC rout_port FIND re(V(out)) AT=1k
.end
