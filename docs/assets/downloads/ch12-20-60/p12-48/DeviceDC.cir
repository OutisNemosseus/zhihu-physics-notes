P12.48 nonlinear device DC verification; LED constant drop as specified
VCC vcc 0 5
VB b 0 3.6
RC vcc d 200
RF s out 500
Q1 d b s QN
Q2 ledtop d vcc QP
VLED ledtop out 1.6
IQ out 0 16m
.model QN NPN (BF=180 IS=1e-15)
.model QP PNP (BF=180 IS=1e-15)
.temp 27
.options numdgt=15 measdgt=12 reltol=1e-9 abstol=1e-14 vntol=1e-10
.dc VCC 5 5.000001 1u
.meas DC ic1 FIND Ic(Q1) AT=5
.meas DC ic2 FIND (-Ic(Q2)) AT=5
.meas DC vout FIND V(out) AT=5
.end
