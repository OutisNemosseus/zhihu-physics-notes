P12.39 nonlinear device DC verification; LED constant drop as specified
VCC vcc 0 5
VSS vss 0 -5
Vin in 0 0
VREF ref 0 -1.5
RD1 vcc d1 7k
RD2 vcc out 7k
R1 out fb 200k
R2 fb ref 200k
M1 d1 in tail tail MN L=1u W=1u
M2 out fb tail tail MN L=1u W=1u
Itail tail vss 1m
.model MN NMOS (LEVEL=1 VTO=0.5 KP=1m LAMBDA=0)
.temp 27
.options numdgt=15 measdgt=12 reltol=1e-9 abstol=1e-14 vntol=1e-10
.dc VCC 5 5.000001 1u
.meas DC id1 FIND Id(M1) AT=5
.meas DC id2 FIND Id(M2) AT=5
.meas DC vout FIND V(out) AT=5
.end
