P12 AC: textbook equivalent; see README.md
Vin in 0 0 AC 1
Rs in b1 2000
Rc1 b2 0 10000
Rc2 b3 0 10000
Re1 e1 0 100
Rf e1 out 6068.49943
Re3 out 0 1000
RL out 0 3000
Rpi1 b1 e1 6240
Gm1 b2 e1 b1 e1 0.0192307692
Rpi2 b2 0 3120
Gm2 b3 0 b2 0 0.0384615385
Rpi3 b3 out 624
Gm3 0 out b3 out 0.192307692
Rbt0 b1 0 179900.053
Rbb0 b1 0 10000
Rbt1 b2 0 182553.191
Rbb1 b2 0 10000
Rbt2 b3 0 93439.8654
Rbb2 b3 0 100000
.ac dec 20 1 1Meg
.options numdgt=15 measdgt=12
.meas AC result FIND re(V(out)*1) AT=1k
.meas AC rin_port FIND re(V(in)/(-I(Vin))) AT=1k
.end
