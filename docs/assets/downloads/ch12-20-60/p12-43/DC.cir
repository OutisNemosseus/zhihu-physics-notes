P12.43 textbook DC: Vbe=0.7 V; Ic=beta*Ib, not a device-model OP
Vcc vcc 0 15
Rbt0 b1 vcc 179900.053
Rbb0 b1 0 10000
Rbt1 b2 vcc 182553.191
Rbb1 b2 0 10000
Rbt2 b3 vcc 93439.8654
Rbb2 b3 0 100000
Rc1 vcc c1 10000
Rc2 vcc c2 10000
Re1 e1 0 100
Re3 out 0 1000
Vbe1 b1 e1 0.7
Fc1 c1 e1 Vbe1 120
Vbe2 b2 0 0.7
Fc2 c2 0 Vbe2 120
Vbe3 b3 out 0.7
Fc3 vcc out Vbe3 120
.dc Vcc 15 15.000001 0.000001
.options numdgt=15 measdgt=12
.meas DC ic1 FIND (I(Vbe1)*120) AT=15
.meas DC ic2 FIND (I(Vbe2)*120) AT=15
.meas DC ic3 FIND (I(Vbe3)*120) AT=15
.meas DC v_b1 FIND V(b1) AT=15
.meas DC v_b2 FIND V(b2) AT=15
.meas DC v_b3 FIND V(b3) AT=15
.meas DC v_c1 FIND V(c1) AT=15
.meas DC v_c2 FIND V(c2) AT=15
.meas DC v_e1 FIND V(e1) AT=15
.meas DC v_out FIND V(out) AT=15
.meas DC v_vcc FIND V(vcc) AT=15
.end
