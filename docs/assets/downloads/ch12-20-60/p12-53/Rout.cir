P12 Rout: textbook equivalent; see README.md
Iin 0 in 0 AC 0
Rs in 0 1e+30
Rb1 in 0 1298.4456
Rc1 b2 0 7000
Rc2 out 0 2200
RL out 0 2000
Re21 e2 tap 250
Re22 tap 0 500
Rf in tap 5000
Rpi1 in 0 1329.71429
Gm1 b2 0 in 0 0.0376020627
Rpi2 b2 e2 478.948146
Gm2 out e2 b2 e2 0.104395435
Itest 0 out 0 AC 1
.ac dec 1 1 1Meg
.options numdgt=15 measdgt=12
.meas AC rout_port FIND re(V(out)) AT=1k
.end
