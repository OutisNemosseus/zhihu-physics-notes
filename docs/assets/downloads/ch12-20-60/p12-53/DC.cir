P12.53 textbook DC: Vbe=0.7 V; Ic=beta*Ib, not a device-model OP
Vcc vcc 0 10
R1 vcc b1 17900
R2 b1 0 1400
Rc1 vcc b2 7000
Rc2 vcc out 2200
Re21 e2 tap 250
Re22 tap 0 500
Vbe1 b1 0 0.7
Fc1 b2 0 Vbe1 50
Vbe2 b2 e2 0.7
Fc2 out e2 Vbe2 50
.dc Vcc 10 10.000001 0.000001
.options numdgt=15 measdgt=12
.meas DC ic1 FIND (I(Vbe1)*50) AT=10
.meas DC ic2 FIND (I(Vbe2)*50) AT=10
.meas DC v_b1 FIND V(b1) AT=10
.meas DC v_b2 FIND V(b2) AT=10
.meas DC v_e2 FIND V(e2) AT=10
.meas DC v_out FIND V(out) AT=10
.meas DC v_tap FIND V(tap) AT=10
.meas DC v_vcc FIND V(vcc) AT=10
.end
